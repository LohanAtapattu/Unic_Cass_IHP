** sch_path: /home/designer/shared/Unic_Cass_IHP/LVS/multiplier_top.sch
.subckt multiplier_top vdd vxp vxn vss on_chip_bias vyp ext_bias vyn vop voutm vom voutp vref Rgm
*.PININFO vxp:B vxn:B vyp:B vyn:B vop:B vom:B vref:B Rgm:B vdd:B vss:B on_chip_bias:B ext_bias:B voutm:B voutp:B
MM1 vxp vyp vop vss sg13_lv_nmos w=2.5u l=2u ng=1 m=4
MM2 vxp vyn vom vss sg13_lv_nmos w=2.5u l=2u ng=1 m=4
MM3 vxn vyn vop vss sg13_lv_nmos w=2.5u l=2u ng=1 m=4
MM4 vxn vyp vom vss sg13_lv_nmos w=2.5u l=2u ng=1 m=4
MM5 vss vss vss vss sg13_lv_nmos w=2.5u l=2u ng=1 m=20
x1 on_chip_bias vref vdd voutm ext_bias vom voutp vss vop Rgm Full_opamp
.ends

* expanding   symbol:  LVS/Unic_cass_final_design_lvs/Simulations/Opamp_design/Src/Full_opamp.sym # of pins=10
** sym_path: /home/designer/shared/Unic_Cass_IHP/LVS/Unic_cass_final_design_lvs/Simulations/Opamp_design/Src/Full_opamp.sym
** sch_path: /home/designer/shared/Unic_Cass_IHP/LVS/Unic_cass_final_design_lvs/Simulations/Opamp_design/Src/Full_opamp.sch
.subckt Full_opamp on_chip_bias vref vdd voutm ext_bias vm voutp vss vp Rgm
*.PININFO on_chip_bias:B ext_bias:B Rgm:B vdd:B vss:B vref:B vm:B vp:B voutm:B voutp:B
CC2 net1 vopx cap_cmim w=10.0e-6 l=10.0e-6 m=8
CC1 net2 vomx cap_cmim w=10.0e-6 l=10.0e-6 m=8
CC4 vdd vdd cap_cmim w=10.0e-6 l=2.0e-6 m=20
RR4 net1 net6 3276.52173913043 $SUB=vss $[rhigh] w=0.5e-6 l=1e-6 b=0
RR5 net6 net7 3276.52173913043 $SUB=vss $[rhigh] w=0.5e-6 l=1e-6 b=0
RR6 net7 net8 3276.52173913043 $SUB=vss $[rhigh] w=0.5e-6 l=1e-6 b=0
RR7 net8 voutm 3276.52173913043 $SUB=vss $[rhigh] w=0.5e-6 l=1e-6 b=0
RR1 net2 net9 3276.52173913043 $SUB=vss $[rhigh] w=0.5e-6 l=1e-6 b=0
RR2 net9 net10 3276.52173913043 $SUB=vss $[rhigh] w=0.5e-6 l=1e-6 b=0
RR3 net10 net11 3276.52173913043 $SUB=vss $[rhigh] w=0.5e-6 l=1e-6 b=0
RR8 net11 voutp 3276.52173913043 $SUB=vss $[rhigh] w=0.5e-6 l=1e-6 b=0
x3 net4 on_chip_bias net5 vdd ext_bias vss net3 Rgm Ibias4 Bias_circuit
x1 net3 net5 net4 vm vp vss vdd vref vopx vomx Folded_cascode
x2 Ibias4 vdd vss vopx vomx voutm voutp vref common_source_stage
.ends

* expanding   symbol:  LVS/Unic_cass_final_design_lvs/Simulations/Opamp_design/Src/Bias_circuit.sym # of pins=9
** sym_path: /home/designer/shared/Unic_Cass_IHP/LVS/Unic_cass_final_design_lvs/Simulations/Opamp_design/Src/Bias_circuit.sym
** sch_path: /home/designer/shared/Unic_Cass_IHP/LVS/Unic_cass_final_design_lvs/Simulations/Opamp_design/Src/Bias_circuit.sch
.subckt Bias_circuit Ibias1 en_1 Ibias2 vdd en_2 vss Ibias3 Rgm Ibias4
*.PININFO en_1:B en_2:B Rgm:B vdd:B vss:B Ibias1:B Ibias2:B Ibias3:B Ibias4:B
MM12 net1 net2 vss vss sg13_lv_nmos w=5u l=2u ng=1 m=2
MM13 net1 net1 vdd vdd sg13_lv_pmos w=0.5u l=10u ng=1 m=2
MM1 Pbias net1 net2 vss sg13_lv_nmos w=0.5u l=10u ng=1 m=40
MM2 net2 Pbias vdd vdd sg13_lv_pmos w=5u l=2u ng=1 m=4
MM3 net2 net2 vss vss sg13_lv_nmos w=5u l=2u ng=1 m=2
MM4 net3 Pbias vdd vdd sg13_lv_pmos w=5u l=2u ng=1 m=4
MM5 net3 net3 beta vss sg13_lv_nmos w=5u l=2u ng=1 m=8
MM6 net6 net6 vdd vdd sg13_lv_pmos w=5u l=2u ng=1 m=4
MM7 Pbias net6 vdd vdd sg13_lv_pmos w=5u l=2u ng=1 m=4
MM8 net6 net3 net4 vss sg13_lv_nmos w=5u l=2u ng=1 m=2
MM9 Pbias net2 net5 vss sg13_lv_nmos w=5u l=2u ng=1 m=2
MM10 Pbias en_1 vdd vdd sg13_lv_pmos w=1u l=0.15u ng=1
MM11 net4 en_1 vss vss sg13_lv_nmos w=1u l=0.15u ng=1 m=10
MM14 net5 en_1 vss vss sg13_lv_nmos w=1u l=0.15u ng=1 m=10
MM15 net7 Ebias vdd vdd sg13_lv_pmos w=5u l=1u ng=1 m=2
MM16 net7 en_2 Ibias1 vss sg13_lv_nmos w=1u l=0.15u ng=1
MM17 net8 Pbias vdd vdd sg13_lv_pmos w=5u l=2u ng=1 m=4
MM18 net8 en_1 Ibias1 vss sg13_lv_nmos w=1u l=0.15u ng=1
MM19 Ebias Ebias vdd vdd sg13_lv_pmos w=5u l=1u ng=1 m=2
MM20 beta en_1 Rgm vss sg13_lv_nmos w=1u l=0.15u ng=1
MM21 Ebias en_2 Rgm vss sg13_lv_nmos w=1u l=0.15u ng=1
MM22 net9 Ebias vdd vdd sg13_lv_pmos w=5u l=1u ng=1 m=2
MM23 net9 en_2 Ibias2 vss sg13_lv_nmos w=1u l=0.15u ng=1
MM24 net10 Pbias vdd vdd sg13_lv_pmos w=5u l=2u ng=1 m=4
MM25 net10 en_1 Ibias2 vss sg13_lv_nmos w=1u l=0.15u ng=1
MM26 net11 Ebias vdd vdd sg13_lv_pmos w=5u l=1u ng=1 m=2
MM27 net11 en_2 Ibias3 vss sg13_lv_nmos w=1u l=0.15u ng=1
MM28 net12 Pbias vdd vdd sg13_lv_pmos w=5u l=2u ng=1 m=4
MM29 net12 en_1 Ibias3 vss sg13_lv_nmos w=1u l=0.15u ng=1
MM30 net13 Ebias vdd vdd sg13_lv_pmos w=5u l=1u ng=1 m=2
MM31 net13 en_2 Ibias4 vss sg13_lv_nmos w=1u l=0.15u ng=1
MM32 net14 Pbias vdd vdd sg13_lv_pmos w=5u l=2u ng=1 m=4
MM33 net14 en_1 Ibias4 vss sg13_lv_nmos w=1u l=0.15u ng=1
MM34 vss vss vss vss sg13_lv_nmos w=5u l=2u ng=1 m=20
MM35 vdd vdd vdd vdd sg13_lv_pmos w=5u l=2u ng=1 m=24
MM36 vdd vdd vdd vdd sg13_lv_pmos w=5u l=1u ng=1 m=18
MM38 vdd vdd vdd vdd sg13_lv_pmos w=5u l=2u ng=1 m=16
MM39 vdd vdd vdd vdd sg13_lv_pmos w=0.5u l=10u ng=1 m=10
.ends

* expanding   symbol:  LVS/Unic_cass_final_design_lvs/Simulations/Opamp_design/Src/Folded_cascode.sym # of pins=10
** sym_path: /home/designer/shared/Unic_Cass_IHP/LVS/Unic_cass_final_design_lvs/Simulations/Opamp_design/Src/Folded_cascode.sym
** sch_path: /home/designer/shared/Unic_Cass_IHP/LVS/Unic_cass_final_design_lvs/Simulations/Opamp_design/Src/Folded_cascode.sch
.subckt Folded_cascode vbias3 vbias2 vbias1 vm vp vss vdd vref vop vom
*.PININFO vbias3:B vbias2:B vbias1:B vm:B vp:B vss:B vdd:B vref:B vop:B vom:B
MM1 net3 vout vdd vdd sg13_lv_pmos w=1u l=5u ng=1 m=8
MM2 net1 vbias1 vss vss sg13_lv_nmos w=0.5u l=10u ng=1 m=4
MM4 net2 vm net1 vss sg13_lv_nmos w=2u l=10u ng=1 m=10
MM5 net3 vp net1 vss sg13_lv_nmos w=2u l=10u ng=1 m=10
MM3 net2 vout vdd vdd sg13_lv_pmos w=1u l=5u ng=1 m=8
MM6 vop vbiasp net2 vdd sg13_lv_pmos w=0.5u l=10u ng=1 m=16
MM7 vom vbiasp net3 vdd sg13_lv_pmos w=0.5u l=10u ng=1 m=16
MM8 vop vbias2 net7 vss sg13_lv_nmos w=1u l=10u ng=1 m=20
MM9 vom vbias2 net8 vss sg13_lv_nmos w=1u l=10u ng=1 m=20
MM10 net7 vbias1 vss vss sg13_lv_nmos w=0.5u l=10u ng=1 m=4
MM11 net8 vbias1 vss vss sg13_lv_nmos w=0.5u l=10u ng=1 m=4
MM12 net6 vom net4 vss sg13_lv_nmos w=0.5u l=10u ng=1 m=10
MM13 vout vref net4 vss sg13_lv_nmos w=0.5u l=10u ng=1 m=10
MM14 net6 vop net5 vss sg13_lv_nmos w=0.5u l=10u ng=1 m=10
MM15 vout vref net5 vss sg13_lv_nmos w=0.5u l=10u ng=1 m=10
MM16 net4 vbias1 vss vss sg13_lv_nmos w=0.5u l=10u ng=1 m=2
MM17 net5 vbias1 vss vss sg13_lv_nmos w=0.5u l=10u ng=1 m=2
MM18 net6 net6 vdd vdd sg13_lv_pmos w=1u l=10u ng=1 m=2
MM19 vout net6 vdd vdd sg13_lv_pmos w=1u l=10u ng=1 m=2
MM20 vbiasp vbiasp vdd vdd sg13_lv_pmos w=0.5u l=10u ng=1 m=6
MM21 vbias3 vbias3 vss vss sg13_lv_nmos w=0.6u l=1u ng=1 m=2
MM22 vbiasp vbias3 vss vss sg13_lv_nmos w=0.6u l=1u ng=1 m=2
MM23 vbias2 vbias2 vss vss sg13_lv_nmos w=1u l=10u ng=1 m=2
MM24 vbias1 vbias1 vss vss sg13_lv_nmos w=0.5u l=10u ng=1 m=20
CC1 vout vop cap_cmim w=10.0e-6 l=10.0e-6 m=8
CC2 vout vom cap_cmim w=10.0e-6 l=10.0e-6 m=8
MM25 vss vss vss vss sg13_lv_nmos w=0.5u l=10u ng=1 m=58
MM26 vss vss vss vss sg13_lv_nmos w=0.5u l=0.5u ng=1 m=54
MM28 vss vss vss vss sg13_lv_nmos w=1u l=0.5u ng=1 m=42
MM31 vss vss vss vss sg13_lv_nmos w=2u l=0.5u ng=1 m=20
MM35 vdd vdd vdd vdd sg13_lv_pmos w=0.5u l=0.5u ng=1 m=44
MM36 vdd vdd vdd vdd sg13_lv_pmos w=0.5u l=10u ng=1 m=6
MM37 vdd vdd vdd vdd sg13_lv_pmos w=0.5u l=0.5u ng=1 m=4
MM38 vdd vdd vdd vdd sg13_lv_pmos w=0.5u l=5u ng=1 m=4
MM39 vdd vdd vdd vdd sg13_lv_pmos w=1u l=0.5u ng=1 m=16
MM40 vss vss vss vss sg13_lv_nmos w=0.6u l=1u ng=1 m=2
MM41 vss vss vss vss sg13_lv_nmos w=0.6u l=0.5u ng=1 m=12
MM42 vdd vdd vdd vdd sg13_lv_pmos w=0.5u l=0.5u ng=1 m=4
MM43 vdd vdd vdd vdd sg13_lv_pmos w=0.5u l=10u ng=1 m=2
MM44 vdd vdd vdd vdd sg13_lv_pmos w=1u l=0.5u ng=1 m=8
CC4 vdd vdd cap_cmim w=10.0e-6 l=2.0e-6 m=20
.ends

* expanding   symbol:  LVS/Unic_cass_final_design_lvs/Simulations/Opamp_design/Src/common_source_stage.sym # of pins=8
** sym_path: /home/designer/shared/Unic_Cass_IHP/LVS/Unic_cass_final_design_lvs/Simulations/Opamp_design/Src/common_source_stage.sym
** sch_path: /home/designer/shared/Unic_Cass_IHP/LVS/Unic_cass_final_design_lvs/Simulations/Opamp_design/Src/common_source_stage.sch
.subckt common_source_stage vbias3 vdd vss vopin vomin vom vop vref
*.PININFO vbias3:B vdd:B vss:B vopin:B vomin:B vom:B vop:B vref:B
MM20 vbiasp vbiasp vdd vdd sg13_lv_pmos w=1u l=5u ng=1 m=60
MM21 vbias3 vbias3 vss vss sg13_lv_nmos w=0.6u l=1u ng=1 m=2
MM22 vbiasp vbias3 vss vss sg13_lv_nmos w=0.6u l=1u ng=1 m=2
MM1 vom vopin vdd vdd sg13_lv_pmos w=2u l=2u ng=1 m=10
MM2 vop vomin vdd vdd sg13_lv_pmos w=2u l=2u ng=1 m=10
MM3 vom vout vss vss sg13_lv_nmos w=1u l=2u ng=1 m=10
MM4 vop vout vss vss sg13_lv_nmos w=1u l=2u ng=1 m=10
MM5 net2 vbiasp vdd vdd sg13_lv_pmos w=1u l=5u ng=1 m=2
MM6 net1 vcm net2 vdd sg13_lv_pmos w=0.5u l=10u ng=1 m=4
MM7 vout vref net2 vdd sg13_lv_pmos w=0.5u l=10u ng=1 m=4
MM8 net1 net1 vss vss sg13_lv_nmos w=0.25u l=10u ng=1 m=2
MM9 vout net1 vss vss sg13_lv_nmos w=0.25u l=10u ng=1 m=2
CC1 vout vom cap_cmim w=10.0e-6 l=10.0e-6 m=3
CC2 vout vop cap_cmim w=10.0e-6 l=10.0e-6 m=3
MM10 vss vss vss vss sg13_lv_nmos w=1u l=2u ng=1 m=22
MM13 vss vss vss vss sg13_lv_nmos w=0.25u l=1u ng=1 m=8
MM14 vdd vdd vdd vdd sg13_lv_pmos w=0.5u l=0.5u ng=1 m=12
MM15 vdd vdd vdd vdd sg13_lv_pmos w=0.5u l=10u ng=1 m=4
MM17 vdd vdd vdd vdd sg13_lv_pmos w=1u l=1u ng=1 m=20
MM18 vss vss vss vss sg13_lv_nmos w=0.6u l=1u ng=1 m=12
MM16 vdd vdd vdd vdd sg13_lv_pmos w=1u l=5u ng=1 m=18
MM11 vdd vdd vdd vdd sg13_lv_pmos w=2u l=2u ng=1 m=22
CC3 vss vss cap_cmim w=10.0e-6 l=2.0e-6 m=10
x1 vom vss vcm res
x2 vop vss vcm res
.ends

* expanding   symbol:  LVS/Unic_cass_final_design_lvs/Simulations/Opamp_design/Src/res.sym # of pins=3
** sym_path: /home/designer/shared/Unic_Cass_IHP/LVS/Unic_cass_final_design_lvs/Simulations/Opamp_design/Src/res.sym
** sch_path: /home/designer/shared/Unic_Cass_IHP/LVS/Unic_cass_final_design_lvs/Simulations/Opamp_design/Src/res.sch
.subckt res vin vss vout
*.PININFO vin:B vout:B vss:B
RR21 vin net4 3276.52173913043 $SUB=vss $[rhigh] w=0.5e-6 l=1e-6 b=0
RR1 net4 net5 3276.52173913043 $SUB=vss $[rhigh] w=0.5e-6 l=1e-6 b=0
RR2 net5 net6 3276.52173913043 $SUB=vss $[rhigh] w=0.5e-6 l=1e-6 b=0
RR3 net6 net7 3276.52173913043 $SUB=vss $[rhigh] w=0.5e-6 l=1e-6 b=0
RR4 net7 net1 3276.52173913043 $SUB=vss $[rhigh] w=0.5e-6 l=1e-6 b=0
RR5 net2 net8 3276.52173913043 $SUB=vss $[rhigh] w=0.5e-6 l=1e-6 b=0
RR6 net8 net9 3276.52173913043 $SUB=vss $[rhigh] w=0.5e-6 l=1e-6 b=0
RR7 net9 net10 3276.52173913043 $SUB=vss $[rhigh] w=0.5e-6 l=1e-6 b=0
RR8 net10 net11 3276.52173913043 $SUB=vss $[rhigh] w=0.5e-6 l=1e-6 b=0
RR9 net11 net1 3276.52173913043 $SUB=vss $[rhigh] w=0.5e-6 l=1e-6 b=0
RR10 net2 net12 3276.52173913043 $SUB=vss $[rhigh] w=0.5e-6 l=1e-6 b=0
RR11 net12 net13 3276.52173913043 $SUB=vss $[rhigh] w=0.5e-6 l=1e-6 b=0
RR12 net13 net14 3276.52173913043 $SUB=vss $[rhigh] w=0.5e-6 l=1e-6 b=0
RR13 net14 net15 3276.52173913043 $SUB=vss $[rhigh] w=0.5e-6 l=1e-6 b=0
RR14 net15 net3 3276.52173913043 $SUB=vss $[rhigh] w=0.5e-6 l=1e-6 b=0
RR15 vout net16 3276.52173913043 $SUB=vss $[rhigh] w=0.5e-6 l=1e-6 b=0
RR16 net16 net17 3276.52173913043 $SUB=vss $[rhigh] w=0.5e-6 l=1e-6 b=0
RR17 net17 net18 3276.52173913043 $SUB=vss $[rhigh] w=0.5e-6 l=1e-6 b=0
RR18 net18 net19 3276.52173913043 $SUB=vss $[rhigh] w=0.5e-6 l=1e-6 b=0
RR19 net19 net3 3276.52173913043 $SUB=vss $[rhigh] w=0.5e-6 l=1e-6 b=0
.ends
